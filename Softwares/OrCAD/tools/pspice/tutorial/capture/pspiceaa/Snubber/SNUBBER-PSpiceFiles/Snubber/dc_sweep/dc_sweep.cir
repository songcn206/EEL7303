** Profile: "Snubber-dc_sweep"  [ F:\pv_work\pplot\mfet\snubber-pspicefiles\snubber\dc_sweep.sim ]

** Creating circuit file "dc_sweep.cir"
** WARNING: THIS AUTOMATICALLY GENERATED FILE MAY BE OVERWRITTEN BY SUBSEQUENT SIMULATIONS

*Libraries:
* Profile Libraries :
* Local Libraries :
* From [PSPICE NETLIST] section of F:\Cadence\SPB_15.2\tools\PSpice\PSpice.ini file:
.lib "nom.lib"

*Analysis directives:
.DC LIN V_V1 0 15 0.25
.PROBE V(alias(*)) I(alias(*)) W(alias(*)) D(alias(*)) NOISE(alias(*))
.INC "..\Snubber.net"

.END
